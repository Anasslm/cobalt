{
  "name": "SYSCTRL",
  "regwidth": "32",
  "clock_primary": "clk_i",
  "reset_primary": "rst_ni",
  "bus_interfaces": [
    {
      "protocol": "reg_iface",
      "direction": "device"
    }
  ],
  "registers": [
    {
      "name": "CHIPID",
      "desc": "Chip Identification register",
      "swaccess": "ro",
      "hwaccess": "hwo",
      "resval": "0",
      "fields": [
        {
          "bits": "31:0",
          "name": "CHIPID",
          "desc": "Chip Identification"
        }
      ]
    },
    {
      "name": "TOHOST",
      "desc": "to host register for comm with testbench",
      "swaccess": "wo",
      "hwaccess": "hro",
      "resval": "0",
      "fields": [
        {
          "bits": "31:0",
          "name": "TOHOST",
          "desc": "TO HOST register for comm with testbench"
        }
      ]
    },
    {
      "name": "FROMHOST",
      "desc": "",
      "swaccess": "ro",
      "hwaccess": "hwo",
      "resval": "0",
      "fields": [
        {
          "bits": "31:0",
          "name": "FROMHOST",
          "desc": "FROM HOST register for comm with testbench"
        }
      ]
    }
  ]
}
